// Design: inverter_1/inverter_1_1_tb
simulator lang=spectre
global 0 vdd!
include "/u/sai9/FreePDK45/osu_soc/lib/files/gpdk45nm.m"

// inverter_1/inverter_1_1/schematic
subckt inverter_1_1 INPUT OUTPUT
    pull_up (vdd! vdd! OUTPUT 0) NMOS_VTL w=90n l=1u ld=105n ls=105n m=1
    inverter_pulldown_NFET (OUTPUT INPUT 0 0) NMOS_VTL w=90n l=50n ld=105n ls=105n m=1
ends inverter_1_1

// inverter_1/inverter_1_1_tb/schematic
I5 (net2 net3) inverter_1_1
INPUT_SIGNAL (net2 0) vsource dc=1.2 type=pulse val0=0 val1=1.2 period=10ns width=5ns
LOAD_CAPACITOR (net3 0) capacitor c=15f
V0 (vdd! 0) vsource dc=1.2V type=dc
simulatorOptions options temp=27
dc dc dev=INPUT_SIGNAL param=dc start=0 stop=1.2
