// Design: res_inverter_1/res_inverter_1_1_man_tb
simulator lang=spectre
global 0 vdd!
include "/u/sai9/FreePDK45/osu_soc/lib/files/gpdk45nm.m"

// inverter_1/group7_enhancement/schematic
subckt group7_enhancement INPUT OUTPUT
    inverter_pulldown_NFET (OUTPUT INPUT 0 0) NMOS_VTL w=90n l=50n ld=105n ls=105n m=1
    R0 (vdd! OUTPUT) resistor r=522.14K
ends group7_enhancement

// res_inverter_1/res_inverter_1_1_man_tb/schematic
I8 (net2 net3) group7_enhancement
INPUT_SIGNAL (net2 0) vsource dc=1.2 type=pulse val0=0 val1=1.2 period=10ns rise=66.67p fall=66.67p width=5ns
LOAD_CAPACITOR (net3 0) capacitor c=15f
V0 (vdd! 0) vsource dc=1.2V type=dc
simulatorOptions options temp=27
dc dc dev=INPUT_SIGNAL param=dc start=0 stop=1.2
